Assumed noisy bench companion: virtual ideal differential source
.include "transmitter-stimulus.sp"
.include "receiver-noise.sp"
Rsourcep srcp diep 50
Rsourcen srcn dien 50
Rpp diep pkp .170474
Rpn dien pkn .176587
Lpp pkp txp 5.06641n
Lpn pkn txn 4.91396n
Kpkg Lpp Lpn .627032
Cpp txp 0 1.19704p
Cpn txn 0 1.34626p
* Lossless balanced transformer: differential PCB channel with no common-mode propagation.
Ebal csrc 0 txp txn 1
Fpos txp 0 Ebal -1
Fneg txn 0 Ebal 1
Tref csrc 0 cload 0 Z0=100 TD=.4n
Vcm cm 0 .75
* Common-mode DC return: receiver ODT projected as a lumped ideal channel.
Ecmhalf halfcm 0 txp 0 .5
Ecmsrc srccm halfcm txn 0 .5
Rcm srccm cm 30
Fcmp txp 0 Ecmsrc -.5
Fcmn txn 0 Ecmsrc -.5
Erxp rxp0 cm cload 0 .5
Erxn rxn0 cm cload 0 -.5
Frxp cload 0 Erxp -.5
Frxn cload 0 Erxn .5
* Winbond LDQS/LDQSB package parasitics; independent lumped package model.
Rrp rxp rkp .42069
Rrn rxn rkn .39422
Lrp rkp rdiep 1.1804n
Lrn rkn rdien 1.1796n
Crp rxp 0 .41107p
Crn rxn 0 .42404p
Rtp rdiep cm 60
Rtn rdien cm 60
Cip rdiep 0 2p
Cin rdien 0 2p

* Identical ideal probe loading in clean and noisy cases.
Cprobep rxp 0 2.00000000000000006e-13
Cproben rxn 0 2.00000000000000006e-13
.options reltol=1e-5 abstol=1e-11 vntol=1e-7 method=trap maxord=2 trtol=3
.control
set wr_vecnames
set wr_singlescale
set numdgt=17
* Saved grid is independent of the electrical integration maximum step.
tran 1.99999999999999996e-12 3.14000000000000032e-08 1.00000000000000002e-08 4.99999999999999990e-13
wrdata adaptive.dat v(txp) v(txn) v(rdiep) v(rdien) v(csrc) v(cload) v(rxp) v(rxn)
linearize v(txp) v(txn) v(rdiep) v(rdien) v(csrc) v(cload) v(rxp) v(rxn)
wrdata waveforms.dat v(txp) v(txn) v(rdiep) v(rdien) v(csrc) v(cload) v(rxp) v(rxn)
echo BANDWIDTH_STRESS_COMPLETE
quit
.endc
.end
