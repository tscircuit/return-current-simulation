DQS route-based estimate: NOT EM/IBIS-validated
.options reltol=1e-6 abstol=1e-12 vntol=1e-8
VREF ref 0 0.75
Vd0p d0pideal 0 PWL(
+ 0 0
+ 1.125e-09 0
+ 1.375e-09 1.5
+ 2.375e-09 1.5
+ 2.625e-09 0
+ 3.625e-09 0
+ 3.875e-09 1.5
+ 4.875e-09 1.5
+ 5.125e-09 0
+ 6.125e-09 0
+ 6.375e-09 1.5
+ 7.375e-09 1.5
+ 7.625e-09 0
+ 8.625e-09 0
+ 8.875e-09 1.5
+ 9.875e-09 1.5
+ 1.0125e-08 0
+ 1.1125e-08 0
+ 1.1375e-08 1.5
+ 1.2375e-08 1.5
+ 1.2625e-08 0
+ 1.3625e-08 0
+ 1.3875e-08 1.5
+ 1.4875e-08 1.5
+ 1.5125e-08 0
+ 1.6125e-08 0
+ 1.6375e-08 1.5
+ 1.7375e-08 1.5
+ 1.7625e-08 0
+ 1.8625e-08 0
+ 1.8875e-08 1.5
+ 1.9875e-08 1.5
+ 2.0125e-08 0
+ 2.1125e-08 0
+ 2.1375e-08 1.5
+ 2.2375e-08 1.5
+ 2.2625e-08 0
+ 2.3625e-08 0
+ 2.3875e-08 1.5
+ 2.4875e-08 1.5
+ 2.5125e-08 0
+ 2.6125e-08 0
+ 2.6375e-08 1.5
+ 2.7375e-08 1.5
+ 2.7625e-08 0
+ 2.8625e-08 0
+ 2.8875e-08 1.5
+ 2.9875e-08 1.5
+ 3.0125e-08 0
+ 3.1125e-08 0
+ 3.1375e-08 1.5
+ 3.2375e-08 1.5
+ 3.2625e-08 0
+ 3.3625e-08 0
+ 3.3875e-08 1.5
+ 3.4875e-08 1.5
+ 3.5125e-08 0
+ 3.6125e-08 0
+ 3.6375e-08 1.5
+ 3.7375e-08 1.5
+ 3.7625e-08 0
+ 3.8625e-08 0
+ 3.8875e-08 1.5
+ 4e-08 1.5
+ )
Rd0pdriver d0pideal d0p0 40
Od0pline d0p0 0 d0pload 0 d0pline
.model d0pline LTRA(R=10.986756837149 L=3.3861008131274e-07 C=1.3298239866765e-10 G=0 LEN=0.045045767121032)
Rd0pterm d0pload ref 60
Cd0pinput d0pload 0 2p
Vd0n d0nideal 0 PWL(
+ 0 1.5
+ 1.125e-09 1.5
+ 1.375e-09 0
+ 2.375e-09 0
+ 2.625e-09 1.5
+ 3.625e-09 1.5
+ 3.875e-09 0
+ 4.875e-09 0
+ 5.125e-09 1.5
+ 6.125e-09 1.5
+ 6.375e-09 0
+ 7.375e-09 0
+ 7.625e-09 1.5
+ 8.625e-09 1.5
+ 8.875e-09 0
+ 9.875e-09 0
+ 1.0125e-08 1.5
+ 1.1125e-08 1.5
+ 1.1375e-08 0
+ 1.2375e-08 0
+ 1.2625e-08 1.5
+ 1.3625e-08 1.5
+ 1.3875e-08 0
+ 1.4875e-08 0
+ 1.5125e-08 1.5
+ 1.6125e-08 1.5
+ 1.6375e-08 0
+ 1.7375e-08 0
+ 1.7625e-08 1.5
+ 1.8625e-08 1.5
+ 1.8875e-08 0
+ 1.9875e-08 0
+ 2.0125e-08 1.5
+ 2.1125e-08 1.5
+ 2.1375e-08 0
+ 2.2375e-08 0
+ 2.2625e-08 1.5
+ 2.3625e-08 1.5
+ 2.3875e-08 0
+ 2.4875e-08 0
+ 2.5125e-08 1.5
+ 2.6125e-08 1.5
+ 2.6375e-08 0
+ 2.7375e-08 0
+ 2.7625e-08 1.5
+ 2.8625e-08 1.5
+ 2.8875e-08 0
+ 2.9875e-08 0
+ 3.0125e-08 1.5
+ 3.1125e-08 1.5
+ 3.1375e-08 0
+ 3.2375e-08 0
+ 3.2625e-08 1.5
+ 3.3625e-08 1.5
+ 3.3875e-08 0
+ 3.4875e-08 0
+ 3.5125e-08 1.5
+ 3.6125e-08 1.5
+ 3.6375e-08 0
+ 3.7375e-08 0
+ 3.7625e-08 1.5
+ 3.8625e-08 1.5
+ 3.8875e-08 0
+ 4e-08 0
+ )
Rd0ndriver d0nideal d0n0 40
Od0nline d0n0 0 d0nload 0 d0nline
.model d0nline LTRA(R=11.11973284101 L=3.3962993137531e-07 C=1.3338292456775e-10 G=0 LEN=0.045168032093374)
Rd0nterm d0nload ref 60
Cd0ninput d0nload 0 2p
Vd1p d1pideal 0 PWL(
+ 0 0
+ 1.125e-09 0
+ 1.375e-09 1.5
+ 2.375e-09 1.5
+ 2.625e-09 0
+ 3.625e-09 0
+ 3.875e-09 1.5
+ 4.875e-09 1.5
+ 5.125e-09 0
+ 6.125e-09 0
+ 6.375e-09 1.5
+ 7.375e-09 1.5
+ 7.625e-09 0
+ 8.625e-09 0
+ 8.875e-09 1.5
+ 9.875e-09 1.5
+ 1.0125e-08 0
+ 1.1125e-08 0
+ 1.1375e-08 1.5
+ 1.2375e-08 1.5
+ 1.2625e-08 0
+ 1.3625e-08 0
+ 1.3875e-08 1.5
+ 1.4875e-08 1.5
+ 1.5125e-08 0
+ 1.6125e-08 0
+ 1.6375e-08 1.5
+ 1.7375e-08 1.5
+ 1.7625e-08 0
+ 1.8625e-08 0
+ 1.8875e-08 1.5
+ 1.9875e-08 1.5
+ 2.0125e-08 0
+ 2.1125e-08 0
+ 2.1375e-08 1.5
+ 2.2375e-08 1.5
+ 2.2625e-08 0
+ 2.3625e-08 0
+ 2.3875e-08 1.5
+ 2.4875e-08 1.5
+ 2.5125e-08 0
+ 2.6125e-08 0
+ 2.6375e-08 1.5
+ 2.7375e-08 1.5
+ 2.7625e-08 0
+ 2.8625e-08 0
+ 2.8875e-08 1.5
+ 2.9875e-08 1.5
+ 3.0125e-08 0
+ 3.1125e-08 0
+ 3.1375e-08 1.5
+ 3.2375e-08 1.5
+ 3.2625e-08 0
+ 3.3625e-08 0
+ 3.3875e-08 1.5
+ 3.4875e-08 1.5
+ 3.5125e-08 0
+ 3.6125e-08 0
+ 3.6375e-08 1.5
+ 3.7375e-08 1.5
+ 3.7625e-08 0
+ 3.8625e-08 0
+ 3.8875e-08 1.5
+ 4e-08 1.5
+ )
Rd1pdriver d1pideal d1p0 40
Od1pline d1p0 0 d1pload 0 d1pline
.model d1pline LTRA(R=10.417075111569 L=3.4004571539426e-07 C=1.3354621550095e-10 G=0 LEN=0.042257263788936)
Rd1pterm d1pload ref 60
Cd1pinput d1pload 0 2p
Vd1n d1nideal 0 PWL(
+ 0 1.5
+ 1.125e-09 1.5
+ 1.375e-09 0
+ 2.375e-09 0
+ 2.625e-09 1.5
+ 3.625e-09 1.5
+ 3.875e-09 0
+ 4.875e-09 0
+ 5.125e-09 1.5
+ 6.125e-09 1.5
+ 6.375e-09 0
+ 7.375e-09 0
+ 7.625e-09 1.5
+ 8.625e-09 1.5
+ 8.875e-09 0
+ 9.875e-09 0
+ 1.0125e-08 1.5
+ 1.1125e-08 1.5
+ 1.1375e-08 0
+ 1.2375e-08 0
+ 1.2625e-08 1.5
+ 1.3625e-08 1.5
+ 1.3875e-08 0
+ 1.4875e-08 0
+ 1.5125e-08 1.5
+ 1.6125e-08 1.5
+ 1.6375e-08 0
+ 1.7375e-08 0
+ 1.7625e-08 1.5
+ 1.8625e-08 1.5
+ 1.8875e-08 0
+ 1.9875e-08 0
+ 2.0125e-08 1.5
+ 2.1125e-08 1.5
+ 2.1375e-08 0
+ 2.2375e-08 0
+ 2.2625e-08 1.5
+ 2.3625e-08 1.5
+ 2.3875e-08 0
+ 2.4875e-08 0
+ 2.5125e-08 1.5
+ 2.6125e-08 1.5
+ 2.6375e-08 0
+ 2.7375e-08 0
+ 2.7625e-08 1.5
+ 2.8625e-08 1.5
+ 2.8875e-08 0
+ 2.9875e-08 0
+ 3.0125e-08 1.5
+ 3.1125e-08 1.5
+ 3.1375e-08 0
+ 3.2375e-08 0
+ 3.2625e-08 1.5
+ 3.3625e-08 1.5
+ 3.3875e-08 0
+ 3.4875e-08 0
+ 3.5125e-08 1.5
+ 3.6125e-08 1.5
+ 3.6375e-08 0
+ 3.7375e-08 0
+ 3.7625e-08 1.5
+ 3.8625e-08 1.5
+ 3.8875e-08 0
+ 4e-08 0
+ )
Rd1ndriver d1nideal d1n0 40
Od1nline d1n0 0 d1nload 0 d1nline
.model d1nline LTRA(R=10.419833097771 L=3.4004790650336e-07 C=1.3354707601562e-10 G=0 LEN=0.042384263788936)
Rd1nterm d1nload ref 60
Cd1ninput d1nload 0 2p
.tran 1e-12 4e-08 0 1e-12
.control
set wr_singlescale
set wr_vecnames
run
wrdata waveforms.csv v(d0pload) v(d0nload) v(d1pload) v(d1nload)
quit
.endc
.end
